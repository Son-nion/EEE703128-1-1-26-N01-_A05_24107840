* NGSPICE file created from A05_array_mult4x4.ext - technology: sky130A

* Black-box entry subcircuit for sky130_ef_sc_hd__decap_12 abstract view
.subckt sky130_ef_sc_hd__decap_12 VPWR VGND VPB VNB
.ends

* Black-box entry subcircuit for sky130_fd_sc_hd__decap_4 abstract view
.subckt sky130_fd_sc_hd__decap_4 VGND VNB VPB VPWR
.ends

* Black-box entry subcircuit for sky130_fd_sc_hd__nor2_1 abstract view
.subckt sky130_fd_sc_hd__nor2_1 A B VGND VNB VPB VPWR Y
.ends

* Black-box entry subcircuit for sky130_fd_sc_hd__o2111a_1 abstract view
.subckt sky130_fd_sc_hd__o2111a_1 A1 A2 B1 C1 D1 VGND VNB VPB VPWR X
.ends

* Black-box entry subcircuit for sky130_fd_sc_hd__clkbuf_4 abstract view
.subckt sky130_fd_sc_hd__clkbuf_4 A VGND VNB VPB VPWR X
.ends

* Black-box entry subcircuit for sky130_fd_sc_hd__fill_1 abstract view
.subckt sky130_fd_sc_hd__fill_1 VGND VNB VPB VPWR
.ends

* Black-box entry subcircuit for sky130_fd_sc_hd__decap_6 abstract view
.subckt sky130_fd_sc_hd__decap_6 VGND VNB VPB VPWR
.ends

* Black-box entry subcircuit for sky130_fd_sc_hd__a22oi_1 abstract view
.subckt sky130_fd_sc_hd__a22oi_1 A1 A2 B1 B2 VGND VNB VPB VPWR Y
.ends

* Black-box entry subcircuit for sky130_fd_sc_hd__decap_8 abstract view
.subckt sky130_fd_sc_hd__decap_8 VGND VNB VPB VPWR
.ends

* Black-box entry subcircuit for sky130_fd_sc_hd__a21oi_1 abstract view
.subckt sky130_fd_sc_hd__a21oi_1 A1 A2 B1 VGND VNB VPB VPWR Y
.ends

* Black-box entry subcircuit for sky130_fd_sc_hd__fill_2 abstract view
.subckt sky130_fd_sc_hd__fill_2 VGND VNB VPB VPWR
.ends

* Black-box entry subcircuit for sky130_fd_sc_hd__inv_2 abstract view
.subckt sky130_fd_sc_hd__inv_2 A VGND VNB VPB VPWR Y
.ends

* Black-box entry subcircuit for sky130_fd_sc_hd__decap_3 abstract view
.subckt sky130_fd_sc_hd__decap_3 VGND VNB VPB VPWR
.ends

* Black-box entry subcircuit for sky130_fd_sc_hd__xnor2_1 abstract view
.subckt sky130_fd_sc_hd__xnor2_1 A B VGND VNB VPB VPWR Y
.ends

* Black-box entry subcircuit for sky130_fd_sc_hd__o21a_1 abstract view
.subckt sky130_fd_sc_hd__o21a_1 A1 A2 B1 VGND VNB VPB VPWR X
.ends

* Black-box entry subcircuit for sky130_fd_sc_hd__buf_2 abstract view
.subckt sky130_fd_sc_hd__buf_2 A VGND VNB VPB VPWR X
.ends

* Black-box entry subcircuit for sky130_fd_sc_hd__a21o_1 abstract view
.subckt sky130_fd_sc_hd__a21o_1 A1 A2 B1 VGND VNB VPB VPWR X
.ends

* Black-box entry subcircuit for sky130_fd_sc_hd__nand4_1 abstract view
.subckt sky130_fd_sc_hd__nand4_1 A B C D VGND VNB VPB VPWR Y
.ends

* Black-box entry subcircuit for sky130_fd_sc_hd__nand2_1 abstract view
.subckt sky130_fd_sc_hd__nand2_1 A B VGND VNB VPB VPWR Y
.ends

* Black-box entry subcircuit for sky130_fd_sc_hd__and3_1 abstract view
.subckt sky130_fd_sc_hd__and3_1 A B C VGND VNB VPB VPWR X
.ends

* Black-box entry subcircuit for sky130_fd_sc_hd__buf_1 abstract view
.subckt sky130_fd_sc_hd__buf_1 A VGND VNB VPB VPWR X
.ends

* Black-box entry subcircuit for sky130_fd_sc_hd__or2b_1 abstract view
.subckt sky130_fd_sc_hd__or2b_1 A B_N VGND VNB VPB VPWR X
.ends

* Black-box entry subcircuit for sky130_fd_sc_hd__xor2_1 abstract view
.subckt sky130_fd_sc_hd__xor2_1 A B VGND VNB VPB VPWR X
.ends

* Black-box entry subcircuit for sky130_fd_sc_hd__mux2_1 abstract view
.subckt sky130_fd_sc_hd__mux2_1 A0 A1 S VGND VNB VPB VPWR X
.ends

* Black-box entry subcircuit for sky130_fd_sc_hd__a31o_1 abstract view
.subckt sky130_fd_sc_hd__a31o_1 A1 A2 A3 B1 VGND VNB VPB VPWR X
.ends

* Black-box entry subcircuit for sky130_fd_sc_hd__tapvpwrvgnd_1 abstract view
.subckt sky130_fd_sc_hd__tapvpwrvgnd_1 VGND VPWR
.ends

* Black-box entry subcircuit for sky130_fd_sc_hd__and2_1 abstract view
.subckt sky130_fd_sc_hd__and2_1 A B VGND VNB VPB VPWR X
.ends

* Black-box entry subcircuit for sky130_fd_sc_hd__and4_1 abstract view
.subckt sky130_fd_sc_hd__and4_1 A B C D VGND VNB VPB VPWR X
.ends

* Black-box entry subcircuit for sky130_fd_sc_hd__clkbuf_1 abstract view
.subckt sky130_fd_sc_hd__clkbuf_1 A VGND VNB VPB VPWR X
.ends

* Black-box entry subcircuit for sky130_fd_sc_hd__a21bo_1 abstract view
.subckt sky130_fd_sc_hd__a21bo_1 A1 A2 B1_N VGND VNB VPB VPWR X
.ends

* Black-box entry subcircuit for sky130_fd_sc_hd__clkbuf_2 abstract view
.subckt sky130_fd_sc_hd__clkbuf_2 A VGND VNB VPB VPWR X
.ends

* Black-box entry subcircuit for sky130_fd_sc_hd__o21ai_1 abstract view
.subckt sky130_fd_sc_hd__o21ai_1 A1 A2 B1 VGND VNB VPB VPWR Y
.ends

* Black-box entry subcircuit for sky130_fd_sc_hd__nand3_1 abstract view
.subckt sky130_fd_sc_hd__nand3_1 A B C VGND VNB VPB VPWR Y
.ends

* Black-box entry subcircuit for sky130_fd_sc_hd__a22o_1 abstract view
.subckt sky130_fd_sc_hd__a22o_1 A1 A2 B1 B2 VGND VNB VPB VPWR X
.ends

* Black-box entry subcircuit for sky130_fd_sc_hd__a221oi_2 abstract view
.subckt sky130_fd_sc_hd__a221oi_2 A1 A2 B1 B2 C1 VGND VNB VPB VPWR Y
.ends

* Black-box entry subcircuit for sky130_fd_sc_hd__a211o_1 abstract view
.subckt sky130_fd_sc_hd__a211o_1 A1 A2 B1 C1 VGND VNB VPB VPWR X
.ends

* Black-box entry subcircuit for sky130_fd_sc_hd__o211ai_2 abstract view
.subckt sky130_fd_sc_hd__o211ai_2 A1 A2 B1 C1 VGND VNB VPB VPWR Y
.ends

.subckt A05_array_mult4x4 VGND VPWR a[0] a[1] a[2] a[3] b[0] b[1] b[2] b[3] p[0] p[1]
+ p[2] p[3] p[4] p[5] p[6] p[7]
XFILLER_0_9_27 VPWR VGND VPWR VGND sky130_ef_sc_hd__decap_12
XFILLER_0_0_29 VGND VGND VPWR VPWR sky130_fd_sc_hd__decap_4
X_062_ _006_ _007_ VGND VGND VPWR VPWR _008_ sky130_fd_sc_hd__nor2_1
XFILLER_0_9_39 VPWR VGND VPWR VGND sky130_ef_sc_hd__decap_12
X_061_ net1 _003_ net2 net5 net6 VGND VGND VPWR VPWR _007_ sky130_fd_sc_hd__o2111a_1
XFILLER_0_6_29 VPWR VGND VPWR VGND sky130_ef_sc_hd__decap_12
Xoutput10 net10 VGND VGND VPWR VPWR p[1] sky130_fd_sc_hd__clkbuf_4
XFILLER_0_3_19 VGND VGND VPWR VPWR sky130_fd_sc_hd__fill_1
XFILLER_0_10_21 VGND VGND VPWR VPWR sky130_fd_sc_hd__decap_6
X_060_ net2 net6 _003_ net5 VGND VGND VPWR VPWR _006_ sky130_fd_sc_hd__a22oi_1
Xoutput9 net9 VGND VGND VPWR VPWR p[0] sky130_fd_sc_hd__clkbuf_4
XFILLER_0_9_3 VGND VGND VPWR VPWR sky130_fd_sc_hd__decap_8
Xoutput11 net11 VGND VGND VPWR VPWR p[2] sky130_fd_sc_hd__clkbuf_4
X_111_ _047_ _051_ _048_ VGND VGND VPWR VPWR net16 sky130_fd_sc_hd__a21oi_1
Xoutput12 net12 VGND VGND VPWR VPWR p[3] sky130_fd_sc_hd__clkbuf_4
XFILLER_0_1_75 VGND VGND VPWR VPWR sky130_fd_sc_hd__fill_2
XFILLER_0_7_52 VGND VGND VPWR VPWR sky130_fd_sc_hd__decap_4
XFILLER_0_4_53 VGND VGND VPWR VPWR sky130_fd_sc_hd__decap_4
XFILLER_0_4_75 VGND VGND VPWR VPWR sky130_fd_sc_hd__fill_2
X_110_ _049_ VGND VGND VPWR VPWR _051_ sky130_fd_sc_hd__inv_2
Xoutput13 net13 VGND VGND VPWR VPWR p[4] sky130_fd_sc_hd__clkbuf_4
XFILLER_0_1_55 VGND VGND VPWR VPWR sky130_fd_sc_hd__fill_1
Xoutput14 net14 VGND VGND VPWR VPWR p[5] sky130_fd_sc_hd__clkbuf_4
XFILLER_0_7_3 VGND VGND VPWR VPWR sky130_fd_sc_hd__fill_2
XFILLER_0_7_10 VPWR VGND VPWR VGND sky130_ef_sc_hd__decap_12
XPHY_0 VGND VGND VPWR VPWR sky130_fd_sc_hd__decap_3
X_099_ _040_ _041_ VGND VGND VPWR VPWR _042_ sky130_fd_sc_hd__xnor2_1
Xoutput15 net15 VGND VGND VPWR VPWR p[6] sky130_fd_sc_hd__clkbuf_4
XPHY_1 VGND VGND VPWR VPWR sky130_fd_sc_hd__decap_3
XFILLER_0_7_22 VGND VGND VPWR VPWR sky130_fd_sc_hd__decap_6
XFILLER_0_10_37 VPWR VGND VPWR VGND sky130_ef_sc_hd__decap_12
XFILLER_0_4_23 VGND VGND VPWR VPWR sky130_fd_sc_hd__decap_4
X_098_ _027_ _031_ _028_ VGND VGND VPWR VPWR _041_ sky130_fd_sc_hd__o21a_1
XFILLER_0_1_57 VGND VGND VPWR VPWR sky130_fd_sc_hd__decap_3
XPHY_2 VGND VGND VPWR VPWR sky130_fd_sc_hd__decap_3
Xoutput16 net16 VGND VGND VPWR VPWR p[7] sky130_fd_sc_hd__buf_2
XFILLER_0_4_57 VGND VGND VPWR VPWR sky130_fd_sc_hd__fill_1
XFILLER_0_10_49 VPWR VGND VPWR VGND sky130_ef_sc_hd__decap_12
XFILLER_0_10_27 VGND VGND VPWR VPWR sky130_fd_sc_hd__fill_1
XFILLER_0_1_25 VGND VGND VPWR VPWR sky130_fd_sc_hd__fill_1
X_097_ _036_ _037_ _039_ VGND VGND VPWR VPWR _040_ sky130_fd_sc_hd__a21o_1
XFILLER_0_7_57 VPWR VGND VPWR VGND sky130_ef_sc_hd__decap_12
XPHY_3 VGND VGND VPWR VPWR sky130_fd_sc_hd__decap_3
XFILLER_0_5_3 VGND VGND VPWR VPWR sky130_fd_sc_hd__fill_2
XFILLER_0_1_48 VGND VGND VPWR VPWR sky130_fd_sc_hd__decap_3
X_096_ _038_ _036_ VGND VGND VPWR VPWR _039_ sky130_fd_sc_hd__nor2_1
XFILLER_0_7_69 VGND VGND VPWR VPWR sky130_fd_sc_hd__decap_4
X_079_ net5 net2 net6 _003_ VGND VGND VPWR VPWR _023_ sky130_fd_sc_hd__nand4_1
XPHY_4 VGND VGND VPWR VPWR sky130_fd_sc_hd__decap_3
XFILLER_0_10_29 VGND VGND VPWR VPWR sky130_fd_sc_hd__fill_2
X_095_ net7 VGND VGND VPWR VPWR _038_ sky130_fd_sc_hd__inv_2
X_078_ _021_ _022_ VGND VGND VPWR VPWR net12 sky130_fd_sc_hd__nor2_1
XPHY_5 VGND VGND VPWR VPWR sky130_fd_sc_hd__decap_3
XFILLER_0_4_27 VGND VGND VPWR VPWR sky130_fd_sc_hd__fill_1
XFILLER_0_4_38 VGND VGND VPWR VPWR sky130_fd_sc_hd__decap_3
X_094_ net7 net4 VGND VGND VPWR VPWR _037_ sky130_fd_sc_hd__nand2_1
X_077_ net1 net8 _020_ VGND VGND VPWR VPWR _022_ sky130_fd_sc_hd__a21oi_1
XPHY_6 VGND VGND VPWR VPWR sky130_fd_sc_hd__decap_3
X_093_ net4 _001_ _025_ VGND VGND VPWR VPWR _036_ sky130_fd_sc_hd__a21oi_1
XFILLER_0_3_3 VGND VGND VPWR VPWR sky130_fd_sc_hd__decap_4
X_076_ net1 net8 _020_ VGND VGND VPWR VPWR _021_ sky130_fd_sc_hd__and3_1
Xinput1 a[0] VGND VGND VPWR VPWR net1 sky130_fd_sc_hd__buf_2
XFILLER_0_7_28 VGND VGND VPWR VPWR sky130_fd_sc_hd__fill_1
X_059_ _003_ _001_ _004_ VGND VGND VPWR VPWR _005_ sky130_fd_sc_hd__and3_1
XPHY_7 VGND VGND VPWR VPWR sky130_fd_sc_hd__decap_3
XFILLER_0_4_18 VGND VGND VPWR VPWR sky130_fd_sc_hd__fill_2
Xinput2 a[1] VGND VGND VPWR VPWR net2 sky130_fd_sc_hd__buf_2
XFILLER_0_11_75 VGND VGND VPWR VPWR sky130_fd_sc_hd__fill_2
X_092_ _021_ _035_ VGND VGND VPWR VPWR net13 sky130_fd_sc_hd__xnor2_1
X_075_ _009_ _019_ VGND VGND VPWR VPWR _020_ sky130_fd_sc_hd__xnor2_1
X_058_ net5 net2 net6 VGND VGND VPWR VPWR _004_ sky130_fd_sc_hd__and3_1
XPHY_8 VGND VGND VPWR VPWR sky130_fd_sc_hd__decap_3
XFILLER_0_8_50 VGND VGND VPWR VPWR sky130_fd_sc_hd__decap_3
Xinput3 a[2] VGND VGND VPWR VPWR net3 sky130_fd_sc_hd__buf_1
X_091_ _033_ _034_ VGND VGND VPWR VPWR _035_ sky130_fd_sc_hd__or2b_1
XFILLER_0_11_10 VGND VGND VPWR VPWR sky130_fd_sc_hd__decap_4
X_074_ _017_ _018_ VGND VGND VPWR VPWR _019_ sky130_fd_sc_hd__nor2_1
XFILLER_0_2_41 VGND VGND VPWR VPWR sky130_fd_sc_hd__decap_6
X_057_ net3 VGND VGND VPWR VPWR _003_ sky130_fd_sc_hd__buf_2
XPHY_9 VGND VGND VPWR VPWR sky130_fd_sc_hd__decap_3
X_109_ _047_ _050_ VGND VGND VPWR VPWR net15 sky130_fd_sc_hd__xor2_1
XFILLER_0_8_73 VGND VGND VPWR VPWR sky130_fd_sc_hd__decap_4
X_090_ net2 net8 _032_ VGND VGND VPWR VPWR _034_ sky130_fd_sc_hd__a21o_1
XFILLER_0_5_74 VGND VGND VPWR VPWR sky130_fd_sc_hd__decap_3
Xinput4 a[3] VGND VGND VPWR VPWR net4 sky130_fd_sc_hd__buf_2
X_073_ _014_ _015_ _016_ VGND VGND VPWR VPWR _018_ sky130_fd_sc_hd__a21oi_1
X_056_ _001_ _002_ VGND VGND VPWR VPWR net10 sky130_fd_sc_hd__nor2_1
XFILLER_0_8_63 VGND VGND VPWR VPWR sky130_fd_sc_hd__decap_3
X_108_ _048_ net8 _049_ VGND VGND VPWR VPWR _050_ sky130_fd_sc_hd__mux2_1
XFILLER_0_5_53 VGND VGND VPWR VPWR sky130_fd_sc_hd__decap_3
XFILLER_0_3_7 VGND VGND VPWR VPWR sky130_fd_sc_hd__fill_1
Xinput5 b[0] VGND VGND VPWR VPWR net5 sky130_fd_sc_hd__buf_2
XFILLER_0_11_67 VGND VGND VPWR VPWR sky130_fd_sc_hd__decap_8
XFILLER_0_11_34 VGND VGND VPWR VPWR sky130_fd_sc_hd__fill_2
X_072_ _014_ _015_ _016_ VGND VGND VPWR VPWR _017_ sky130_fd_sc_hd__and3_1
X_055_ net5 net2 net6 net1 VGND VGND VPWR VPWR _002_ sky130_fd_sc_hd__a22oi_1
X_107_ net7 net4 _041_ _039_ VGND VGND VPWR VPWR _049_ sky130_fd_sc_hd__a31o_1
XFILLER_0_5_21 VGND VGND VPWR VPWR sky130_fd_sc_hd__fill_2
XTAP_40 VGND VPWR sky130_fd_sc_hd__tapvpwrvgnd_1
X_071_ net2 net7 VGND VGND VPWR VPWR _016_ sky130_fd_sc_hd__and2_1
Xinput6 b[1] VGND VGND VPWR VPWR net6 sky130_fd_sc_hd__buf_2
XFILLER_0_2_55 VPWR VGND VPWR VGND sky130_ef_sc_hd__decap_12
X_054_ net5 net1 net2 net6 VGND VGND VPWR VPWR _001_ sky130_fd_sc_hd__and4_1
X_106_ net4 net8 VGND VGND VPWR VPWR _048_ sky130_fd_sc_hd__nand2_1
XFILLER_0_5_33 VPWR VGND VPWR VGND sky130_ef_sc_hd__decap_12
X_070_ _012_ _013_ _007_ VGND VGND VPWR VPWR _015_ sky130_fd_sc_hd__a21o_1
Xinput7 b[2] VGND VGND VPWR VPWR net7 sky130_fd_sc_hd__buf_2
XTAP_30 VGND VPWR sky130_fd_sc_hd__tapvpwrvgnd_1
X_053_ _000_ VGND VGND VPWR VPWR net9 sky130_fd_sc_hd__clkbuf_1
XFILLER_0_2_67 VGND VGND VPWR VPWR sky130_fd_sc_hd__decap_6
X_105_ _043_ _046_ _044_ VGND VGND VPWR VPWR _047_ sky130_fd_sc_hd__a21bo_1
XFILLER_0_5_45 VGND VGND VPWR VPWR sky130_fd_sc_hd__decap_8
XFILLER_0_11_26 VGND VGND VPWR VPWR sky130_fd_sc_hd__decap_3
Xinput8 b[3] VGND VGND VPWR VPWR net8 sky130_fd_sc_hd__clkbuf_2
XTAP_31 VGND VPWR sky130_fd_sc_hd__tapvpwrvgnd_1
X_104_ _045_ _046_ VGND VGND VPWR VPWR net14 sky130_fd_sc_hd__xor2_1
X_052_ net5 net1 VGND VGND VPWR VPWR _000_ sky130_fd_sc_hd__and2_1
XFILLER_0_11_49 VGND VGND VPWR VPWR sky130_fd_sc_hd__fill_2
XTAP_32 VGND VPWR sky130_fd_sc_hd__tapvpwrvgnd_1
XFILLER_0_5_57 VGND VGND VPWR VPWR sky130_fd_sc_hd__decap_8
XFILLER_0_5_13 VGND VGND VPWR VPWR sky130_fd_sc_hd__decap_8
XFILLER_0_2_47 VGND VGND VPWR VPWR sky130_fd_sc_hd__fill_1
X_103_ _021_ _033_ _034_ VGND VGND VPWR VPWR _046_ sky130_fd_sc_hd__o21ai_1
XTAP_33 VGND VPWR sky130_fd_sc_hd__tapvpwrvgnd_1
XFILLER_0_2_15 VPWR VGND VPWR VGND sky130_ef_sc_hd__decap_12
X_102_ _043_ _044_ VGND VGND VPWR VPWR _045_ sky130_fd_sc_hd__nand2_1
XFILLER_0_8_25 VGND VGND VPWR VPWR sky130_fd_sc_hd__decap_3
XFILLER_0_8_3 VGND VGND VPWR VPWR sky130_fd_sc_hd__decap_4
XTAP_34 VGND VPWR sky130_fd_sc_hd__tapvpwrvgnd_1
XFILLER_0_2_27 VGND VGND VPWR VPWR sky130_fd_sc_hd__fill_1
X_101_ _003_ net8 _042_ VGND VGND VPWR VPWR _044_ sky130_fd_sc_hd__a21o_1
XTAP_35 VGND VPWR sky130_fd_sc_hd__tapvpwrvgnd_1
XFILLER_0_12_51 VGND VGND VPWR VPWR sky130_fd_sc_hd__decap_4
X_100_ _003_ net8 _042_ VGND VGND VPWR VPWR _043_ sky130_fd_sc_hd__nand3_1
XFILLER_0_8_38 VPWR VGND VPWR VGND sky130_ef_sc_hd__decap_12
XFILLER_0_10_9 VPWR VGND VPWR VGND sky130_ef_sc_hd__decap_12
XTAP_36 VGND VPWR sky130_fd_sc_hd__tapvpwrvgnd_1
XPHY_20 VGND VGND VPWR VPWR sky130_fd_sc_hd__decap_3
XFILLER_0_2_29 VPWR VGND VPWR VGND sky130_ef_sc_hd__decap_12
XFILLER_0_3_50 VGND VGND VPWR VPWR sky130_fd_sc_hd__decap_6
XFILLER_0_3_61 VPWR VGND VPWR VGND sky130_ef_sc_hd__decap_12
XFILLER_0_0_51 VGND VGND VPWR VPWR sky130_fd_sc_hd__decap_4
XPHY_21 VGND VGND VPWR VPWR sky130_fd_sc_hd__decap_3
XTAP_37 VGND VPWR sky130_fd_sc_hd__tapvpwrvgnd_1
XFILLER_0_6_61 VPWR VGND VPWR VGND sky130_ef_sc_hd__decap_12
XTAP_26 VGND VPWR sky130_fd_sc_hd__tapvpwrvgnd_1
XPHY_10 VGND VGND VPWR VPWR sky130_fd_sc_hd__decap_3
XFILLER_0_3_73 VGND VGND VPWR VPWR sky130_fd_sc_hd__decap_4
X_089_ net2 net8 _032_ VGND VGND VPWR VPWR _033_ sky130_fd_sc_hd__and3_1
XFILLER_0_8_29 VGND VGND VPWR VPWR sky130_fd_sc_hd__fill_2
XTAP_38 VGND VPWR sky130_fd_sc_hd__tapvpwrvgnd_1
XFILLER_0_8_7 VGND VGND VPWR VPWR sky130_fd_sc_hd__fill_1
XTAP_27 VGND VPWR sky130_fd_sc_hd__tapvpwrvgnd_1
XFILLER_0_12_65 VGND VGND VPWR VPWR sky130_fd_sc_hd__decap_3
XPHY_22 VGND VGND VPWR VPWR sky130_fd_sc_hd__decap_3
XFILLER_0_6_73 VGND VGND VPWR VPWR sky130_fd_sc_hd__decap_4
XPHY_11 VGND VGND VPWR VPWR sky130_fd_sc_hd__decap_3
X_088_ _029_ _031_ VGND VGND VPWR VPWR _032_ sky130_fd_sc_hd__xnor2_1
XFILLER_0_9_51 VGND VGND VPWR VPWR sky130_fd_sc_hd__decap_4
XTAP_39 VGND VPWR sky130_fd_sc_hd__tapvpwrvgnd_1
XFILLER_0_6_41 VPWR VGND VPWR VGND sky130_ef_sc_hd__decap_12
XPHY_12 VGND VGND VPWR VPWR sky130_fd_sc_hd__decap_3
XTAP_28 VGND VPWR sky130_fd_sc_hd__tapvpwrvgnd_1
XFILLER_0_12_55 VGND VGND VPWR VPWR sky130_fd_sc_hd__fill_1
XPHY_23 VGND VGND VPWR VPWR sky130_fd_sc_hd__decap_3
X_087_ _009_ _030_ _018_ VGND VGND VPWR VPWR _031_ sky130_fd_sc_hd__a21oi_1
XFILLER_0_0_10 VGND VGND VPWR VPWR sky130_fd_sc_hd__decap_6
XFILLER_0_0_21 VGND VGND VPWR VPWR sky130_fd_sc_hd__decap_6
XPHY_24 VGND VGND VPWR VPWR sky130_fd_sc_hd__decap_3
XPHY_13 VGND VGND VPWR VPWR sky130_fd_sc_hd__decap_3
XFILLER_0_6_53 VGND VGND VPWR VPWR sky130_fd_sc_hd__fill_1
XTAP_29 VGND VPWR sky130_fd_sc_hd__tapvpwrvgnd_1
XFILLER_0_4_3 VGND VGND VPWR VPWR sky130_fd_sc_hd__decap_4
X_086_ _014_ _015_ _016_ VGND VGND VPWR VPWR _030_ sky130_fd_sc_hd__nand3_1
X_069_ _007_ _012_ _013_ VGND VGND VPWR VPWR _014_ sky130_fd_sc_hd__nand3_1
XFILLER_0_0_44 VGND VGND VPWR VPWR sky130_fd_sc_hd__fill_1
XFILLER_0_0_55 VGND VGND VPWR VPWR sky130_fd_sc_hd__fill_1
XFILLER_0_6_21 VGND VGND VPWR VPWR sky130_fd_sc_hd__decap_6
XPHY_25 VGND VGND VPWR VPWR sky130_fd_sc_hd__decap_3
XFILLER_0_12_57 VGND VGND VPWR VPWR sky130_fd_sc_hd__fill_2
XFILLER_0_12_13 VPWR VGND VPWR VGND sky130_ef_sc_hd__decap_12
XPHY_14 VGND VGND VPWR VPWR sky130_fd_sc_hd__decap_3
X_085_ _027_ _028_ VGND VGND VPWR VPWR _029_ sky130_fd_sc_hd__or2b_1
XFILLER_0_9_76 VGND VGND VPWR VPWR sky130_fd_sc_hd__fill_1
X_068_ net5 net6 _003_ net4 VGND VGND VPWR VPWR _013_ sky130_fd_sc_hd__nand4_1
XFILLER_0_12_25 VGND VGND VPWR VPWR sky130_fd_sc_hd__decap_3
XPHY_15 VGND VGND VPWR VPWR sky130_fd_sc_hd__decap_3
XFILLER_0_9_55 VGND VGND VPWR VPWR sky130_fd_sc_hd__fill_1
XFILLER_0_9_11 VGND VGND VPWR VPWR sky130_fd_sc_hd__fill_1
X_084_ _003_ net7 _026_ VGND VGND VPWR VPWR _028_ sky130_fd_sc_hd__a21o_1
XFILLER_0_0_57 VPWR VGND VPWR VGND sky130_ef_sc_hd__decap_12
X_067_ net6 _003_ net4 net5 VGND VGND VPWR VPWR _012_ sky130_fd_sc_hd__a22o_1
XFILLER_0_6_9 VPWR VGND VPWR VGND sky130_ef_sc_hd__decap_12
XPHY_16 VGND VGND VPWR VPWR sky130_fd_sc_hd__decap_3
XFILLER_0_2_3 VPWR VGND VPWR VGND sky130_ef_sc_hd__decap_12
X_083_ _003_ net7 _026_ VGND VGND VPWR VPWR _027_ sky130_fd_sc_hd__and3_1
X_066_ _011_ VGND VGND VPWR VPWR net11 sky130_fd_sc_hd__clkbuf_1
XPHY_17 VGND VGND VPWR VPWR sky130_fd_sc_hd__decap_3
XFILLER_0_4_7 VGND VGND VPWR VPWR sky130_fd_sc_hd__fill_1
X_082_ net4 _001_ _023_ _024_ _025_ VGND VGND VPWR VPWR _026_ sky130_fd_sc_hd__a221oi_2
X_065_ _009_ _010_ VGND VGND VPWR VPWR _011_ sky130_fd_sc_hd__and2_1
XFILLER_0_9_68 VGND VGND VPWR VPWR sky130_fd_sc_hd__decap_8
XFILLER_0_12_39 VPWR VGND VPWR VGND sky130_ef_sc_hd__decap_12
XPHY_18 VGND VGND VPWR VPWR sky130_fd_sc_hd__decap_3
X_081_ net5 net6 net3 net4 VGND VGND VPWR VPWR _025_ sky130_fd_sc_hd__and4_1
XFILLER_0_3_15 VGND VGND VPWR VPWR sky130_fd_sc_hd__decap_4
XFILLER_0_3_26 VPWR VGND VPWR VGND sky130_ef_sc_hd__decap_12
XFILLER_0_10_61 VPWR VGND VPWR VGND sky130_ef_sc_hd__decap_12
XFILLER_0_0_16 VGND VGND VPWR VPWR sky130_fd_sc_hd__fill_1
XFILLER_0_0_27 VGND VGND VPWR VPWR sky130_fd_sc_hd__fill_1
XFILLER_0_0_38 VGND VGND VPWR VPWR sky130_fd_sc_hd__decap_6
X_064_ net1 net7 _005_ _008_ VGND VGND VPWR VPWR _010_ sky130_fd_sc_hd__a211o_1
XPHY_19 VGND VGND VPWR VPWR sky130_fd_sc_hd__decap_3
XFILLER_0_12_29 VGND VGND VPWR VPWR sky130_fd_sc_hd__fill_2
XFILLER_0_3_38 VPWR VGND VPWR VGND sky130_ef_sc_hd__decap_12
X_080_ net6 net4 VGND VGND VPWR VPWR _024_ sky130_fd_sc_hd__nand2_1
X_063_ _005_ _008_ net1 net7 VGND VGND VPWR VPWR _009_ sky130_fd_sc_hd__o211ai_2
XFILLER_0_10_73 VGND VGND VPWR VPWR sky130_fd_sc_hd__decap_4
XFILLER_0_9_15 VPWR VGND VPWR VGND sky130_ef_sc_hd__decap_12
XFILLER_0_6_27 VGND VGND VPWR VPWR sky130_fd_sc_hd__fill_1
.ends
